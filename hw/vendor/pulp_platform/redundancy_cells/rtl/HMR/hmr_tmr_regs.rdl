// Copyright 2025 ETH Zurich and University of Bologna.
// Copyright and related rights are licensed under the Solderpad Hardware
// License, Version 0.51 (the "License"); you may not use this file except in
// compliance with the License.  You may obtain a copy of the License at
// http://solderpad.org/licenses/SHL-0.51. Unless required by applicable law
// or agreed to in writing, software, hardware and materials distributed under
// this License is distributed on an "AS IS" BASIS, WITHOUT WARRANTIES OR
// CONDITIONS OF ANY KIND, either express or implied. See the License for the
// specific language governing permissions and limitations under the License.

addrmap hmr_tmr {
    reg tmr_enable {
        name = "tmr_enable";
        desc = "TMR Configuration Enable";
        field {
            name = "enable";
            desc = "Enable TMR mode";
            sw = rw;
            hw = rw;
            // swmod = true;
            we = true;
        } tmr_enable[0:0] = 0x0;
    };
    reg tmr_config {
        name = "tmr_config";
        desc = "TMR Configuration Register";
        field {
            name = "delay_resynch";
            desc = "Enable wait-for-restoration.";
            sw = rw;
            hw = rw;
            // swmod = true;
            we = true;
        } delay_resynch[0:0] = 0x0;
        field {
            name = "setback";
            desc = "Enable setback (synchronous reset) during re-synch.";
            sw = rw;
            hw = rw;
            // swmod = true;
            we = true;
        } setback[1:1] = 0x1;
        field {
            name = "reload_setback";
            desc = "Enable reload of the setback value from the register.";
            sw = rw;
            hw = rw;
            // swmod = true;
            we = true;
        } reload_setback[2:2] = 0x1;
        field {
            name = "rapid_recovery";
            desc = "Enable rapid recovery using an additional register file.";
            sw = rw;
            hw = rw;
            // swmod = true;
            we = true;
        } rapid_recovery[3:3] = 0x0;
        field {
            name = "force_resynch";
            desc = "Forces a resynchronization routine.";
            sw = rw;
            hw = rw;
            // swmod = true;
            we = true;
        } force_resynch[4:4] = 0x0;
    };

    tmr_enable tmr_enable;
    tmr_config tmr_config;
};
