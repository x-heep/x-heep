// Copyright 2022 ETH Zurich and University of Bologna.
// Licensed under the Apache License, Version 2.0, see LICENSE for details.
// SPDX-License-Identifier: Apache-2.0
//
// Author: Tim Fischer <fischeti@iis.ee.ethz.ch>

{
  name: "serial_link",
  clock_primary: "clk_i"
  reset_primary: "rst_ni"
  bus_interfaces: [
      { protocol: "reg_iface", direction: "device"}
  ]
  regwidth: "32",
  param_list: [
    { name: "NumChannels",
      desc: "Number of channels",
      type: "int",
      default: "38",
      local: "true"
    },
    { name: "Log2NumChannels",
      desc: "Number of channels",
      type: "int",
      default: "6",
      local: "true"
    },
    { name: "NumBits",
      desc: "Number of bits transfered in one clock cycle (2 * NumLanes)",
      type: "int",
      default: "16",
      local: "true"
    },
    { name: "Log2MaxClkDiv",
      desc: "Number of bits for clock divider counter",
      type: "int",
      default: "10",
      local: "true"
    },
    { name: "FlushCounterWidth",
      desc: "The number of bits used for the auto-flush counters in the channel allocator"
      type: "int",
      default: "8",
      local: "true"
    },
    { name: "Log2RawModeTXFifoDepth",
      desc: "The depth of the TX FIFO for raw mode operation."
      type: "int",
      default: "3",
      local: "true"
    }
  ],

  registers: [
    {
      name: "CTRL",
      desc: "Global clock, isolation and reset control configuration"
      swaccess: "rw",
      hwaccess: "hro",
      // Clock disabled (i.e. gated) by default
      fields: [
        {
          bits: "0",
          name: "clk_ena",
          desc: "Clock gate enable for network, link, physical layer. (active-high)",
          resval: 0,
        },
        {
          bits: "1",
          name: "reset_n",
          resval: 1,
          // *Not* held in reset (i.e. signal high) by default.
          // Since clock is gated on reset, inner serial link state should *not* change until ungate.
          desc: "SW controlled synchronous reset. (active-low)"
        },
        // All channels isolated by default
        {
          bits: "8",
          name: "axi_in_isolate",
          resval: 1,
          desc: "Isolate AXI slave in port. (active-high)"
        },
        {
          bits: "9",
          name: "axi_out_isolate",
          resval: 1,
          desc: "Isolate AXI master out port. (active-high)"
        }
      ]
    },
    {
      name: "ISOLATED",
      desc: "Isolation status of AXI ports",
      swaccess: "ro",
      hwaccess: "hwo",
      hwqe: "true",
      hwext: "true",
      // All channels isolated by default
      fields: [
        {bits: "0:0", name: "axi_in",  resval: 1, desc: "slave in isolation status"},
        {bits: "1:1", name: "axi_out", resval: 1, desc: "master out isolation status"},
      ]
    },
    { multireg:
      {
        name: "TX_PHY_CLK_DIV",
        desc: "Holds clock divider factor for forwarded clock of the TX Phys",
        count: "NumChannels",
        cname: "TX_PHY_CLK_DIV",
        swaccess: "rw",
        hwaccess: "hro",
        compact: false,
        fields: [
          { bits: "Log2MaxClkDiv:0",
            desc: "Clock division factor of TX clock",
            name: "clk_divs",
            resval: 8
          }
        ]
      }
    },
    { multireg:
      {
        name: "TX_PHY_CLK_START",
        desc: "Controls duty cycle and phase of rising edge in TX Phys",
        count: "NumChannels",
        cname: "TX_PHY_CLK_START",
        compact: false,
        swaccess: "rw",
        hwaccess: "hro",
        fields: [
          { bits: "Log2MaxClkDiv:0",
            name: "clk_shift_start",
            desc: "Positive Edge of divided, shifted clock",
            resval: 2
          }
        ]
      }
    },
    { multireg:
      {
        name: "TX_PHY_CLK_END",
        desc: "Controls duty cycle and phase of falling edge in TX Phys",
        count: "NumChannels",
        cname: "TX_PHY_CLK_END",
        compact: false,
        swaccess: "rw",
        hwaccess: "hro",
        fields: [
          { bits: "Log2MaxClkDiv:0",
            name: "clk_shift_end",
            desc: "Negative Edge of divided, shifted clock",
            resval: 6
          }
        ]
      }
    },
    {
      name: "RAW_MODE_EN",
      desc: "Enables Raw mode",
      swaccess: "wo",
      hwaccess: "hro",
      fields: [
        {bits: "0", resval: 0}
      ]
    },
    {
      name: "RAW_MODE_IN_CH_SEL",
      desc: "Receive channel select in RAW mode",
      swaccess: "wo",
      hwaccess: "hro",
      fields: [
        { bits: "Log2NumChannels-1:0",
          resval: 0
        }
      ]
    },
    {multireg:
      {
        name: "RAW_MODE_IN_DATA_VALID"
        cname: "RAW_MODE_IN_DATA_VALID"
        count: "NumChannels",
        compact: "true",
        desc: "Mask for valid data in RX FIFOs during RAW mode."
        swaccess: "ro",
        hwaccess: "hwo",
        hwext: "true",
        fields: [
          {
            bits: "0"
          },
        ]
      }
    },
    {
      name: "RAW_MODE_IN_DATA",
      desc: "Data received by the selected channel in RAW mode",
      swaccess: "ro",
      hwaccess: "hrw",
      hwext: "true",
      hwre: "true",
      fields: [
        { bits: "NumBits-1:0",
        }
      ]
    },
    {multireg:
      {
        name: "RAW_MODE_OUT_CH_MASK"
        cname: "RAW_MODE_OUT_CH_MASK"
        count: "NumChannels",
        compact: "true",
        desc: "Selects channels to send out data in RAW mode, '1 corresponds to broadcasting"
        swaccess: "wo",
        hwaccess: "hro",
        fields: [
          {
            bits: "0",
            resval: 0
          },
        ]
      }
    },
    {
      name: "RAW_MODE_OUT_DATA_FIFO",
      desc: "Data that will be pushed to the RAW mode output FIFO",
      swaccess: "wo",
      hwaccess: "hro",
      hwqe: "true",
      fields: [
        { bits: "NumBits-1:0",
          resval: 0
        }
      ]
    },
    {
      name: "RAW_MODE_OUT_DATA_FIFO_CTRL",
      desc: "Status and control register for the RAW mode data out FIFO",
      swaccess: "rw",
      hwaccess: "hrw",
      hwext: "true",
      hwqe: "true",
      fields: [
        {
          bits: "0",
          name: "clear",
          swaccess: "wo",
          hwaccess: "hro",
          desc: "Clears the raw mode TX FIFO.",
        },
        {
          bits: "8+Log2RawModeTXFifoDepth-1:8",
          name: "fill_state",
          swaccess: "ro",
          hwaccess: "hwo",
          desc: "The number of elements currently stored in the RAW mode TX FIFO that are ready to be sent.",
          resval: 0
        },
        {
          bits: "31",
          name: "is_full",
          swaccess: "ro",
          hwaccess: "hwo",
          desc: "If '1' the FIFO is full and does not accept any more items. Any additional write to the data fill register will be ignored until there is sufficient space again.",
          resval: 0
        }
      ]
    },
    {
      name: "RAW_MODE_OUT_EN",
      desc: "Enable transmission of data currently hold in the output FIFO",
      swaccess: "rw",
      hwaccess: "hro",
      fields: [
        { bits: "0",
          resval: 0
        }
      ]
    },
    {
      name: "FLOW_CONTROL_FIFO_CLEAR",
      desc: "Clears the flow control Fifo",
      swaccess: "wo",
      hwaccess: "hro",
      hwext: "true",
      hwqe: "true",
      fields: [
        { bits: "0",
          resval: 0
        }
      ]
    },
    {
      name: "CHANNEL_ALLOC_TX_CFG"
      desc: "Configuration settings for the TX side in the channel allocator"
      swaccess: "rw",
      hwaccess: "hro",
      fields: [
        {
          bits: "0",
          name: "bypass_en",
          desc: "Enable bypassing the TX channel allocator"
          resval: 1
        },
        {
          bits: "1",
          name: "auto_flush_en",
          desc: "Enable the auto-flush feature of the TX side in the channel allocator"
          resval: 1
        },
        {
          bits: "15:8",
          name: "auto_flush_count",
          desc: "The number of cycles to wait before auto flushing (sending) packets in the channel allocator",
          resval: 2
        }
      ]
    },
    {multireg:
      {
        name: "CHANNEL_ALLOC_TX_CH_EN"
        cname: "CHANNEL_ALLOC_TX_CH_EN"
        count: "NumChannels",
        compact: "true",
        desc: "Channel enable mask for the TX side."
        swaccess: "rw",
        hwaccess: "hro",
        fields: [
          {
            bits: "0",
            resval: 1
          },
        ]
      }
    },
    {
      name: "CHANNEL_ALLOC_TX_CTRL",
      desc: "Soft clear or force flush the TX side of the channel allocator",
      swaccess: "wo",
      hwaccess: "hro",
      hwext: "true",
      hwqe: "true",
      fields: [
        {
          bits: "0",
          name: "clear",
          desc: "Software clear the TX side of the channel allocator",
        },
        {
          bits: "1",
          name: "flush",
          desc: "Flush (transmit remaining data) in the TX side of the channel allocator.",
        }
      ]
    },
    {
      name: "CHANNEL_ALLOC_RX_CFG"
      desc: "Configuration settings for the RX side in the channel allocator"
      swaccess: "rw",
      hwaccess: "hro",
      fields: [
        {
          bits: "0",
          name: "bypass_en",
          desc: "Enable bypassing the RX channel allocator"
          resval: 1
        },
        {
          bits: "1",
          name: "auto_flush_en",
          desc: "Enable the auto-flush feature of the RX side in the channel allocator"
          resval: 1
        },
        {
          bits: "15:8",
          name: "auto_flush_count",
          desc: "The number of cycles to wait before synchronizing on partial packets on the RX side",
          resval: 2
        },
        {
          bits: "16",
          name: "sync_en",
          desc: "Enable (1) or disable (0) the synchronization barrier between the channels (needs to be disabled in raw mode).",
          resval: 1
        }
      ]
    },
    {
      name: "CHANNEL_ALLOC_RX_CTRL",
      desc: "Soft clear the RX side of the channel allocator",
      swaccess: "wo",
      hwaccess: "hro",
      hwext: "true",
      hwqe: "true",
      fields: [
        {
          bits: "0",
          name: "clear",
          desc: "Software clear the TX side of the channel allocator",
        }
      ]
    },
    {multireg:
      {
        name: "CHANNEL_ALLOC_RX_CH_EN"
        cname: "CHANNEL_ALLOC_RX_CH_EN"
        count: "NumChannels",
        compact: "true",
        desc: "Channel enable mask for the RX side."
        swaccess: "rw",
        hwaccess: "hro",
        fields: [
          {
            bits: "0",
            resval: 1
          },
        ]
      }
    },
  ]
}
