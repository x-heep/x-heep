{ name: "camera"
  clock_primary: "clk_i"
  bus_interfaces: [
    { protocol: "reg_iface", direction: "device" }
  ]
  regwidth: "32"

  registers: [
    { name: "CONTROL"
      desc: "Control register for flash controller"
      swaccess: "rw"
      hwaccess: "hro"
      fields: [
        { bits: "2", name: "RESET", desc: "Control the camera reset", resval: "0x0" }
        { bits: "1", name: "PWND", desc: "Control the camera power-down", resval: "0x0" }
        { bits: "0", name: "START", desc: "Start operation", resval: "0x0" }
      ]
    }

    { name: "STATUS"
      desc: "Status register for flash controller"
      swaccess: "ro"
      hwaccess: "hrw"
      fields: [
        { bits: "0", name: "RUNNING", desc: "Frame is running", resval: "0x0" }
      ]
    }
    {window: {
        name: "DATA",
        items: "1",
        validbits: "32",
        desc: '''Camera data window.
                 '''
        swaccess: "ro",
      }
    }
  ]
}
