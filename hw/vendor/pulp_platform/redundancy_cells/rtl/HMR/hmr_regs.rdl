// Copyright 2025 ETH Zurich and University of Bologna.
// Copyright and related rights are licensed under the Solderpad Hardware
// License, Version 0.51 (the "License"); you may not use this file except in
// compliance with the License.  You may obtain a copy of the License at
// http://solderpad.org/licenses/SHL-0.51. Unless required by applicable law
// or agreed to in writing, software, hardware and materials distributed under
// this License is distributed on an "AS IS" BASIS, WITHOUT WARRANTIES OR
// CONDITIONS OF ANY KIND, either express or implied. See the License for the
// specific language governing permissions and limitations under the License.

addrmap hmr #(
    longint unsigned NumCores = 12,
    longint unsigned NumDMRGroups = 6,
    longint unsigned NumTMRGroups = 4
) {

    reg avail_config {
        name = "avail_config";
        desc = "Available Configurations from implemented hardware.";
        field {
            name = "independent";
            desc = "1 if independent mode is available";
            sw = r;
            hw = w;
        } independent[0:0] = 0x1;
        field {
            name = "dual";
            desc = "1 if dual/DMR mode is available";
            sw = r;
            hw = w;
        } dual[1:1] = 0x1;
        field {
            name = "triple";
            desc = "1 if triple/TMR mode is available";
            sw = r;
            hw = w;
        } triple[2:2] = 0x1;
        field {
            name = "rapid_recovery";
            desc = "Number of cores in the system.";
            sw = r;
            hw = w;
        } rapid_recovery[8:8] = 0x1;
    };

    reg cores_en {
        name = "cores_en";
        desc = "Enabled cores, based on the configuration. Can be used for barriers.";
        field {
            name = "cores_en";
            desc = "Enabled cores.";
            sw = r;
            hw = w;
        } cores_en[NumCores-1:0] = 0x0;
    };

    reg dmr_enable {
        name = "dmr_enable";
        desc = "DMR configuration enable, on bit per DMR group.";
        field {
            name = "dmr_enable";
            desc = "Enable DMR mode";
            sw = rw;
            hw = rw;
            swmod = true;
        } dmr_enable[NumDMRGroups-1:0] = 0x0;
    };

    reg tmr_enable {
        name = "tmr_enable";
        desc = "TMR configuration enable, on bit per TMR group.";
        field {
            name = "tmr_enable";
            desc = "Enable TMR mode";
            sw = rw;
            hw = rw;
            swmod = true;
        } tmr_enable[NumTMRGroups-1:0] = 0x0;
    };
    reg dmr_config { // From hmr_dmr_regs.rdl
        name = "dmr_config";
        desc = "DMR Configuration Register";
        field {
            name = "rapid_recovery";
            desc = "Enable rapid recovery using an additional register file.";
            sw = rw;
            hw = rw;
            swmod = true;
        } rapid_recovery[0:0] = 0x0;
        field {
            name = "force_recovery";
            desc = "Forces recovery routine (if rapid_recovery is available).";
            sw = rw;
            hw = rw;
            swmod = true;
        } force_recovery[1:1] = 0x0;
    };
    reg tmr_config { // From hmr_tmr_regs.rdl
        name = "tmr_config";
        desc = "TMR Configuration Register";
        field {
            name = "delay_resynch";
            desc = "Enable wait-for-restoration.";
            sw = rw;
            hw = rw;
            swmod = true;
        } delay_resynch[0:0] = 0x0;
        field {
            name = "setback";
            desc = "Enable setback (synchronous reset) during re-synch.";
            sw = rw;
            hw = rw;
            swmod = true;
        } setback[1:1] = 0x1;
        field {
            name = "reload_setback";
            desc = "Enable reload of the setback value from the register.";
            sw = rw;
            hw = rw;
            swmod = true;
        } reload_setback[2:2] = 0x1;
        field {
            name = "rapid_recovery";
            desc = "Enable rapid recovery using an additional register file.";
            sw = rw;
            hw = rw;
            swmod = true;
        } rapid_recovery[3:3] = 0x0;
        field {
            name = "force_resynch";
            desc = "Forces a resynchronization routine.";
            sw = rw;
            hw = rw;
            swmod = true;
        } force_resynch[4:4] = 0x0;
    };


    external avail_config avail_config;
    external cores_en     cores_en;
    external dmr_enable   dmr_enable;
    external tmr_enable   tmr_enable;
    external dmr_config   dmr_config;
    external tmr_config   tmr_config;
};
