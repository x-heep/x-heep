{
  name: "HMR_tmr_regs",
  clock_primary: "clk_i",
  reset_primary: "rst_ni",
  bus_interfaces: [
    { protocol: "reg_iface",
      direction: "device"
    }
  ],

  regwidth: "32",

  registers: [
    { name: "TMR_enable",
      desc: "TMR configuration enable.",
      swaccess: "rw",
      hwaccess: "hrw",
      hwqe: "true",
      resval: "0",
      fields: [
        { bits: "0",
          name: "TMR_enable",
          desc: "TMR configuration enable."
        }
      ]
    },
    { name: "TMR_config",
      desc: "TMR configuration bits."
      swaccess: "rw",
      hwaccess: "hrw",
      hwqe: "true",
      fields: [
        { bits: "0",
          name: "delay_resynch",
          resval: "0",
          desc: "Enable wait-for-restoration"
        },
        { bits: "1",
          name: "setback",
          resval: "1",
          desc: "Enable setback (synchronous reset) during re-synch."
        },
        { bits: "2",
          name: "reload_setback",
          resval: "1",
          desc: "Enable setback on mismatch during reload section of re-synch (only possible with `setback`)"
        },
        { bits: "3",
          name: "rapid_recovery",
          desc: "Enable rapid recovery using additional register file."
        },
        { bits: "4",
          name: "force_resynch",
          resval: "0",
          desc: "Forces a resynchronization routine"
        }
      ]
    }
  ]
}
